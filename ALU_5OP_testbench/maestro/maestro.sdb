ADE simulation setup
Run mode: Single Run, Sweeps and Corners
Tests:
  Muhib_LIB_ALU_5OP_testbench_1: Muhib_LIB/ALU_5OP_testbench/schematic, simulator spectre
