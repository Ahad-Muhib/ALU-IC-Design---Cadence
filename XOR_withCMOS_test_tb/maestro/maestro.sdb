ADE simulation setup
Run mode: Single Run, Sweeps and Corners
Tests:
  Muhib_LIB_XOR_withCMOS_test_1: Muhib_LIB/XOR_withCMOS_test/schematic, simulator spectre
