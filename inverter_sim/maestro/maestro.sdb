ADE simulation setup
Run mode: Single Run, Sweeps and Corners
Tests:
  Muhib_LIB_inverter_sim_1: Muhib_LIB/inverter_sim/schematic, simulator spectre
