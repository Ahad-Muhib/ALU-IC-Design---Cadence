ADE simulation setup
Test Muhib_LIB_inverter_sim_1: Muhib_LIB/inverter_sim/schematic, simulator spectre
  Models: /home/cadence/tech/gpdk045_v_6_0/gpdk045/../models/spectre/gpdk045.scs[mc]
  Temperature: 27
  Analysis dc: sweep /V0.dc start=0 stop=1.8
  Signals: /VIN, /VOUT
Run mode: Single Run, Sweeps and Corners
