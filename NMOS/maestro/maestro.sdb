ADE simulation setup
Run mode: Single Run, Sweeps and Corners
Tests:
  Muhib_LIB_NMOS_1: Muhib_LIB/NMOS/schematic, simulator spectre
    Variables: vgs = {From/To}Auto:0:5:1.8{From/To}
