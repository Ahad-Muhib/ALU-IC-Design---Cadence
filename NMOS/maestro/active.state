ADE simulation setup
Test Muhib_LIB_NMOS_1: Muhib_LIB/NMOS/schematic, simulator spectre
  Models: /home/cadence/tech/gpdk045_v_6_0/gpdk045/../models/spectre/gpdk045.scs[mc]
  Variables: vgs = {From/To}Auto:0:5:1.8{From/To}
  Temperature: 27
  Analysis dc: sweep /V1.dc start=0 stop=1.8 step=0.01
  Signals: /NM0/D (terminal)
Run mode: Single Run, Sweeps and Corners
