ADE simulation setup
Run mode: Single Run, Sweeps and Corners
Tests:
  Muhib_LIB_XOR_1: Muhib_LIB/XOR/schematic, simulator spectre
