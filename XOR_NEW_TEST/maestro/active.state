ADE simulation setup
Test Muhib_LIB_XOR_withCMOS_test_1: Muhib_LIB/XOR_withCMOS_test/schematic, simulator spectre
  Models: /home/cadence/tech/gpdk045_v_6_0/gpdk045/../models/spectre/gpdk045.scs[mc]
  Temperature: 27
  Analysis tran: stop=150n
  Signals: /Pin1, /Pin2, /Out
Run mode: Single Run, Sweeps and Corners
