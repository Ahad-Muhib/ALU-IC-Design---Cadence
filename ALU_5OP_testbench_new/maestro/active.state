ADE simulation setup
Test Muhib_LIB_ALU_5OP_testbench_1: Muhib_LIB/ALU_5OP_testbench/schematic, simulator spectre
  Models: /home/cadence/tech/gpdk045_v_6_0/gpdk045/../models/spectre/gpdk045.scs[mc]
  Temperature: 27
  Analysis tran: stop=160u
  Signals: /A3, /A2, /A1, /A0, /B3, /B2, /B1, /B0, /RESULT3, /RESULT2, /RESULT1, /RESULT0, /COUT, /OP2, /OP1, /OP0
Run mode: Single Run, Sweeps and Corners
