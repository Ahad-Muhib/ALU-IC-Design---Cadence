ADE simulation setup
Run mode: Single Run, Sweeps and Corners
Tests:
  Muhib_LIB_NAND_tb_1: Muhib_LIB/NAND_tb/schematic, simulator spectre
