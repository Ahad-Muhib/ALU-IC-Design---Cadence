ADE simulation setup
Test Muhib_LIB_NAND_tb_1: Muhib_LIB/NAND_tb/schematic, simulator spectre
  Models: /home/cadence/tech/gpdk045_v_6_0/gpdk045/../models/spectre/gpdk045.scs[mc]
  Temperature: 27
  Analysis dc: sweep /V1.dc start=0 stop=1.8
  Signals: /VIN1, /VIN2, /VOUT
Run mode: Single Run, Sweeps and Corners
