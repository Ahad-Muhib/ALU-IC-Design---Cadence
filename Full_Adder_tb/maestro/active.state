ADE simulation setup
Test Muhib_LIB_Full_Adder_tb_1: Muhib_LIB/Full_Adder_tb/schematic, simulator spectre
  Models: /home/cadence/tech/gpdk045_v_6_0/gpdk045/../models/spectre/gpdk045.scs[mc]
  Temperature: 27
  Analysis tran: stop=150n
  Signals: /A, /B, /Cin, /Cout, /S
Run mode: Single Run, Sweeps and Corners
