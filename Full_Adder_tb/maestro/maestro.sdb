ADE simulation setup
Run mode: Single Run, Sweeps and Corners
Tests:
  Muhib_LIB_Full_Adder_tb_1: Muhib_LIB/Full_Adder_tb/schematic, simulator spectre
