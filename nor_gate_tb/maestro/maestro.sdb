ADE simulation setup
Run mode: Single Run, Sweeps and Corners
Tests:
  Muhib_LIB_nor_gate_tb_1: Muhib_LIB/nor_gate_tb/schematic, simulator spectre
