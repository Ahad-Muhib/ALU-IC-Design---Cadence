ADE simulation setup
Test Muhib_LIB_nor_gate_tb_1: Muhib_LIB/nor_gate_tb/schematic, simulator spectre
  Models: /home/cadence/tech/gpdk045_v_6_0/gpdk045/../models/spectre/gpdk045.scs[mc]
  Temperature: 27
  Analysis dc: sweep /V2.dc start=0 stop=1.8
  Signals: /vin1, /vin2, /vout
Run mode: Single Run, Sweeps and Corners
