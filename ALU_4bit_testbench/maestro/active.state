ADE simulation setup
Test Muhib_LIB_ALU_4bit_testbench_1: Muhib_LIB/ALU_4bit_testbench/schematic, simulator spectre
  Models: /home/cadence/tech/gpdk045_v_6_0/gpdk045/../models/spectre/gpdk045.scs[mc]
  Temperature: 27
  Analysis tran: stop=512u
  Signals: /A0, /A1, /A2, /A3, /B0, /B1, /B2, /B3, /OP, /RES0, /RES1, /RES2, /RES3, /COUT
Run mode: Single Run, Sweeps and Corners
