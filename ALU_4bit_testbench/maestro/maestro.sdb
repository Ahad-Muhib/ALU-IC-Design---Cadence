ADE simulation setup
Run mode: Single Run, Sweeps and Corners
Tests:
  Muhib_LIB_ALU_4bit_testbench_1: Muhib_LIB/ALU_4bit_testbench/schematic, simulator spectre
